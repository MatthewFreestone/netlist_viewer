* Simple RLC Circuit
V1 in 0 AC 1
R1 in mid 100
L1 mid out 10m
C1 out 0 1u
